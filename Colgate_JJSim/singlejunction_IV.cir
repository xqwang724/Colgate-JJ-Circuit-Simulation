* Generated by Xic from cell singlejunction_IV
*.tran 0.2p 0.1n uic
.tran 0.02p 0.1n uic
.plot tran @I0[c] v(2)
.model jj01 jj(rtype=0, cct=1,vg=2.6m, delv=0.08m, icrit=45u, rn=40, cap=0.059p)
B0 2 0 3 jj01 area=1
I0 0 2 pulse(0,1000u,0,0,0,1n,0)
R0 2 0 40
.save @I0[c]
