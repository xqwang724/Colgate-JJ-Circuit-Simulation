* Generated by Xic from cell multineurons
.tran 0.01p 0.1n uic
.plot tran v(19) v(17) v(18)
.model jj02 jj(rtype=0, cct=1, vg=2.6m, delv=0.08m, icrit=45u, rn=40, cap=0.059p)
B0 2 3 6 JJ02 area=1
B1 5 0 7 JJ02 area=1
I0 0 4 86u
I1 0 2 pulse(0,40u,0p,0,0,2n,4n)
L0 3 4 0.2p
L1 4 5 8p
L2 2 0 8p
R0 2 3 10.9091
R1 5 0 10.9091
.save @I0[c]
.save @I1[c]
