* Generated by Xic from cell singleneuron
.tran 0.001p 0.1n uic
.plot tran @I1[c] v(6) v(7) L1#branch @I0[c]
.model jj02 jj(rtype=0, cct=1, vg=2.6m, delv=0.08m, icrit=45u, rn=40, cap=0.059p)
B0 2 3 6 JJ02 area=1
B1 5 0 7 JJ02 area=1
*I0 0 4 100u
I0 0 4 pulse(0,100u,100p,0,0,5n,30n)
L0 3 4 0.2p
L1 4 5 8p
L2 2 0 8p
R0 2 3 10
R1 5 0 10
.save @I0[c]
.save @I1[c]
